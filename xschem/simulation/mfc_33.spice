** sch_path: /home/ttuser/Mfcs/mfc_33/xschem/mfc_33.sch
.subckt mfc_33 gate sbd
*.PININFO gate:I sbd:O
XM2 sbd gate sbd sbd sky130_fd_pr__nfet_01v8 L=1.2 W=3.36 nf=1 m=1
.ends
.end
